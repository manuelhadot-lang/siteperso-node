* CD
V_GImp_1 n5 0 PULSE(0 5 0 1n 1n 250.000m 500.000m)
V_VCC_1 n69 0 DC 5
V_VMR1 n63 0 DC 0
V_VMR2 n67 0 DC 0
V_VMS1 n70 0 DC 0
V_VMS2 n71 0 DC 0
B_HC90_1_mr n9 0 V = { u(V(n63)-2.5)*u(V(n67)-2.5)*5 }
B_HC90_1_ms n11 0 V = { u(V(n70)-2.5)*u(V(n71)-2.5)*5 }
B_HC90_1_rstm n12 0 V = { (u(V(n9)-2.5)+u(V(n11)-2.5)-u(V(n9)-2.5)*u(V(n11)-2.5))*5 }
V_HC90_1_setlo n14 0 DC 0
B_HC90_1_dec n8 0 V = { u(V(n2)-2.5)*u(V(n1)-2.5)*5 }
B_HC90_1_mreff n10 0 V = { (u(V(n9)-2.5)+u(V(n8)-2.5)-u(V(n9)-2.5)*u(V(n8)-2.5))*5 }
B_HC90_1_rstmeff n13 0 V = { (u(V(n12)-2.5)+u(V(n8)-2.5)-u(V(n12)-2.5)*u(V(n8)-2.5))*5 }
R_HC90_1_u0_setpd n11 0 1e9
R_HC90_1_u0_rstpd n10 0 1e9
B_HC90_1_u0_clkinv n128 0 V = { 5 - V(n5) }
C_HC90_1_u0_cedge n128 n15 1e-8
R_HC90_1_u0_cedge n15 0 100000
B_HC90_1_u0_qi n17 0 V = { (1-(u(V(n10)-2.5)))*( (u(V(n11)-2.5))*5 + (1-(u(V(n11)-2.5)))*(((u(V(n128)-2.5)*u(V(n128)-V(n15)-0.3)))*((1-u(V(n3)-2.5))*5) + (1-((u(V(n128)-2.5)*u(V(n128)-V(n15)-0.3))))*(u(V(n3)-2.5)*5)) ) }
R_HC90_1_u0_q n17 n3 10000
C_HC90_1_u0_st n17 0 1e-7
B_HC90_1_u0_qbar n16 0 V = { (1-u(V(n3)-2.5))*5 }
C_HC90_1_u0_dhold n16 0 5e-11
R_HC90_1_u1_setpd n14 0 1e9
R_HC90_1_u1_rstpd n13 0 1e9
C_HC90_1_u1_cedge n3 n26 1e-8
R_HC90_1_u1_cedge n26 0 100000
B_HC90_1_u1_qi n28 0 V = { (1-(u(V(n13)-2.5)))*( (u(V(n14)-2.5))*5 + (1-(u(V(n14)-2.5)))*(((u(V(n26)-2.5)*u(V(n26)-V(n3)-0.3)))*((1-u(V(n1)-2.5))*5) + (1-((u(V(n26)-2.5)*u(V(n26)-V(n3)-0.3))))*(u(V(n1)-2.5)*5)) ) }
R_HC90_1_u1_q n28 n1 10000
C_HC90_1_u1_st n28 0 1e-7
B_HC90_1_u1_qbar n27 0 V = { (1-u(V(n1)-2.5))*5 }
C_HC90_1_u1_dhold n27 0 5e-11
R_HC90_1_u2_setpd n14 0 1e9
R_HC90_1_u2_rstpd n13 0 1e9
C_HC90_1_u2_cedge n1 n38 1e-8
R_HC90_1_u2_cedge n38 0 100000
B_HC90_1_u2_qi n40 0 V = { (1-(u(V(n13)-2.5)))*( (u(V(n14)-2.5))*5 + (1-(u(V(n14)-2.5)))*(((u(V(n38)-2.5)*u(V(n38)-V(n1)-0.3)))*((1-u(V(n7)-2.5))*5) + (1-((u(V(n38)-2.5)*u(V(n38)-V(n1)-0.3))))*(u(V(n7)-2.5)*5)) ) }
R_HC90_1_u2_q n40 n7 10000
C_HC90_1_u2_st n40 0 1e-7
B_HC90_1_u2_qbar n39 0 V = { (1-u(V(n7)-2.5))*5 }
C_HC90_1_u2_dhold n39 0 5e-11
R_HC90_1_u3_setpd n11 0 1e9
R_HC90_1_u3_rstpd n10 0 1e9
C_HC90_1_u3_cedge n7 n50 1e-8
R_HC90_1_u3_cedge n50 0 100000
B_HC90_1_u3_qi n52 0 V = { (1-(u(V(n10)-2.5)))*( (u(V(n11)-2.5))*5 + (1-(u(V(n11)-2.5)))*(((u(V(n50)-2.5)*u(V(n50)-V(n7)-0.3)))*((1-u(V(n2)-2.5))*5) + (1-((u(V(n50)-2.5)*u(V(n50)-V(n7)-0.3))))*(u(V(n2)-2.5)*5)) ) }
R_HC90_1_u3_q n52 n2 10000
C_HC90_1_u3_st n52 0 1e-7
B_HC90_1_u3_qbar n51 0 V = { (1-u(V(n2)-2.5))*5 }
C_HC90_1_u3_dhold n51 0 5e-11
B_AND_1 n66 0 V = { (u(V(n1)-2.5))*(u(V(n2)-2.5))*5 }
B_HC90_2_mr n75 0 V = { u(V(n63)-2.5)*u(V(n67)-2.5)*5 }
B_HC90_2_ms n77 0 V = { u(V(n70)-2.5)*u(V(n71)-2.5)*5 }
B_HC90_2_rstm n78 0 V = { (u(V(n75)-2.5)+u(V(n77)-2.5)-u(V(n75)-2.5)*u(V(n77)-2.5))*5 }
V_HC90_2_setlo n80 0 DC 0
B_HC90_2_dec n74 0 V = { u(V(n64)-2.5)*u(V(n73)-2.5)*5 }
B_HC90_2_mreff n76 0 V = { (u(V(n75)-2.5)+u(V(n74)-2.5)-u(V(n75)-2.5)*u(V(n74)-2.5))*5 }
B_HC90_2_rstmeff n79 0 V = { (u(V(n78)-2.5)+u(V(n74)-2.5)-u(V(n78)-2.5)*u(V(n74)-2.5))*5 }
R_HC90_2_u0_setpd n77 0 1e9
R_HC90_2_u0_rstpd n76 0 1e9
B_HC90_2_u0_clkinv n129 0 V = { 5 - V(n66) }
C_HC90_2_u0_cedge n129 n81 1e-8
R_HC90_2_u0_cedge n81 0 100000
B_HC90_2_u0_qi n83 0 V = { (1-(u(V(n76)-2.5)))*( (u(V(n77)-2.5))*5 + (1-(u(V(n77)-2.5)))*(((u(V(n129)-2.5)*u(V(n129)-V(n81)-0.3)))*((1-u(V(n62)-2.5))*5) + (1-((u(V(n129)-2.5)*u(V(n129)-V(n81)-0.3))))*(u(V(n62)-2.5)*5)) ) }
R_HC90_2_u0_q n83 n62 10000
C_HC90_2_u0_st n83 0 1e-7
B_HC90_2_u0_qbar n82 0 V = { (1-u(V(n62)-2.5))*5 }
C_HC90_2_u0_dhold n82 0 5e-11
R_HC90_2_u1_setpd n80 0 1e9
R_HC90_2_u1_rstpd n79 0 1e9
C_HC90_2_u1_cedge n62 n92 1e-8
R_HC90_2_u1_cedge n92 0 100000
B_HC90_2_u1_qi n94 0 V = { (1-(u(V(n79)-2.5)))*( (u(V(n80)-2.5))*5 + (1-(u(V(n80)-2.5)))*(((u(V(n92)-2.5)*u(V(n92)-V(n62)-0.3)))*((1-u(V(n73)-2.5))*5) + (1-((u(V(n92)-2.5)*u(V(n92)-V(n62)-0.3))))*(u(V(n73)-2.5)*5)) ) }
R_HC90_2_u1_q n94 n73 10000
C_HC90_2_u1_st n94 0 1e-7
B_HC90_2_u1_qbar n93 0 V = { (1-u(V(n73)-2.5))*5 }
C_HC90_2_u1_dhold n93 0 5e-11
R_HC90_2_u2_setpd n80 0 1e9
R_HC90_2_u2_rstpd n79 0 1e9
C_HC90_2_u2_cedge n73 n104 1e-8
R_HC90_2_u2_cedge n104 0 100000
B_HC90_2_u2_qi n106 0 V = { (1-(u(V(n79)-2.5)))*( (u(V(n80)-2.5))*5 + (1-(u(V(n80)-2.5)))*(((u(V(n104)-2.5)*u(V(n104)-V(n73)-0.3)))*((1-u(V(n72)-2.5))*5) + (1-((u(V(n104)-2.5)*u(V(n104)-V(n73)-0.3))))*(u(V(n72)-2.5)*5)) ) }
R_HC90_2_u2_q n106 n72 10000
C_HC90_2_u2_st n106 0 1e-7
B_HC90_2_u2_qbar n105 0 V = { (1-u(V(n72)-2.5))*5 }
C_HC90_2_u2_dhold n105 0 5e-11
R_HC90_2_u3_setpd n77 0 1e9
R_HC90_2_u3_rstpd n76 0 1e9
C_HC90_2_u3_cedge n72 n116 1e-8
R_HC90_2_u3_cedge n116 0 100000
B_HC90_2_u3_qi n118 0 V = { (1-(u(V(n76)-2.5)))*( (u(V(n77)-2.5))*5 + (1-(u(V(n77)-2.5)))*(((u(V(n116)-2.5)*u(V(n116)-V(n72)-0.3)))*((1-u(V(n64)-2.5))*5) + (1-((u(V(n116)-2.5)*u(V(n116)-V(n72)-0.3))))*(u(V(n64)-2.5)*5)) ) }
R_HC90_2_u3_q n118 n64 10000
C_HC90_2_u3_st n118 0 1e-7
B_HC90_2_u3_qbar n117 0 V = { (1-u(V(n64)-2.5))*5 }
C_HC90_2_u3_dhold n117 0 5e-11

.tran 2.58000m 129
.control
set wr_singlescale
tran 2.58000m 129
wrdata __TRAN_WAVE_PATH__ time v(n3) v(n1) v(n7) v(n2) v(n66) v(n62) v(n73) v(n72) v(n64)
quit
.endc
.end
