* test alt freq
B1 out 0 V={5*sin(6.283185307179586*(floor(time*1)*3.141592653589793*(400+1200)/(2*1)+if((time-floor(time*1)/1)<0.5,6.283185307179586*1200*(time-floor(time*1)/1),3.141592653589793*1200/1+6.283185307179586*400*((time-floor(time*1)/1)-0.5))))}
Rload out 0 1Meg
.tran 0.001 1
.end
