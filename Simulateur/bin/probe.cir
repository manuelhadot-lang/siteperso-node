.control
devhelp d_jk
devhelp jk
devhelp d_jkff
.quit
.endc
